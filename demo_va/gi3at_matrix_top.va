// gi3at_matrix_top.va
// GI3AT POI Engine — Top-level 1024×1024 matrix arithmetic unit
// Pure Light Implementation on SiPh MZI mesh with TMR fault tolerance.
//
// Hierarchy (mirrors AnalogAEngine tier structure):
//   Tier 0  — Master arbitration  (1 GI3AT group, global 1024²)
//   Tier 1  — Quadrant dispatch   (4 groups, 256×256 each)
//   Tier 2  — MZI tile execution  (16 groups, 64×64 tiles)
//   Tier 3  — OPA waveguide layer (16 groups, element-level)
//
// Total proxy elements: 108  (1+4+48+16 groups × 3 proxies each)
//
// VCSEL pump:  850 nm fundamental
//              425 nm (SHG, χ², η=42%)
//              283 nm (THG, χ³ cascaded, η=18%)
//
// MQTT fault bus voltages:
//   fault_bus = 0.0 V  → sys/GI3AT/ok
//   fault_bus = 1.0 V  → warn/.../split   (2-of-3, soft error)
//   fault_bus = 2.0 V  → fault/.../TMR    HALT "UNRECOVERABLE ERROR"
//
// Extracted from analog_a_engine.py :: AnalogAEngine (Tiers 0–3)
//              pdk_gds_tapout.py :: FAB_PDK  (IMEC / TSMC / Tower / GF / ams)

`include "disciplines.vams"
`include "constants.vams"

module gi3at_matrix_top(
    // ── Matrix operand buses (amplitude-encoded optical fields) ───────────────
    in_a,           // operand A input bus
    in_b,           // operand B input bus
    result_out,     // voted result output

    // ── VCSEL pump ports ──────────────────────────────────────────────────────
    vcsel_anode, vcsel_cathode,
    vcsel_out_850, vcsel_out_425, vcsel_out_283,

    // ── Control / status ──────────────────────────────────────────────────────
    op_ctrl,        // operation selector  0=MUL 1=ADD 2=SUB 3=DIV  (0–3 V)
    fault_bus,      // aggregated MQTT fault bus output (0/1/2 V)
    heal_trigger,   // pulse high to trigger γ/δ auto-heal across all proxies

    // ── Heater / compensation buses (per tier) ────────────────────────────────
    heater_t0,      // Tier 0 master arbitration heater
    heater_t1,      // Tier 1 quadrant dispatch heaters (4-wire bus, avg)
    heater_t2,      // Tier 2 tile execution heaters
    heater_t3       // Tier 3 OPA element heaters
);

    // ── Port directions ───────────────────────────────────────────────────────
    inout  electrical in_a, in_b;
    output electrical result_out;
    inout  electrical vcsel_anode, vcsel_cathode;
    output electrical vcsel_out_850, vcsel_out_425, vcsel_out_283;
    input  electrical op_ctrl;
    output electrical fault_bus;
    input  electrical heal_trigger;
    input  electrical heater_t0, heater_t1, heater_t2, heater_t3;

    // ── Engine-wide configuration ─────────────────────────────────────────────
    parameter integer matrix_dim    = 1024  from [1:4096];  // N for N×N op
    parameter integer tile_dim      = 64    from [8:256];   // MZI tile size
    parameter integer quadrant_dim  = 256   from [16:1024]; // Tier-1 block

    // ── VCSEL parameters ──────────────────────────────────────────────────────
    parameter real vcsel_lambda_nm  = 850.0  from (400:2000];
    parameter real vcsel_power_dBm  = 3.0;   // 2 mW per emitter
    parameter real freq_double_eta  = 0.42   from (0:1];   // SHG efficiency
    parameter real freq_triple_eta  = 0.18   from (0:1];   // THG efficiency

    // ── MZI mesh parameters ───────────────────────────────────────────────────
    parameter real mzi_loss_dB      = 0.35   from (0:inf);
    parameter real insertion_loss_dB = 1.2   from (0:inf);
    parameter integer phase_bits    = 8      from [4:16];

    // ── SiPh compensation (global engine) ────────────────────────────────────
    parameter real alpha_phase      = 0.0;
    parameter real beta_amplitude   = 1.0   from (0:2];
    parameter real gamma_ppm_K      = 0.0;
    parameter real delta_nm_offset  = 0.0;

    // ── TMR parameters ────────────────────────────────────────────────────────
    parameter real  agree_threshold = 1.0e-4 from (0:1];
    parameter integer halt_on_disagree = 1   from [0:1];

    // ── PDK / FAB selection (affects layer mapping only) ─────────────────────
    // 0=IMEC iSiPP50G  1=TSMC SiPho  2=Tower SiPh  3=GF90WG  4=ams X-FAB
    parameter integer fab_target    = 0     from [0:4];
    parameter real node_nm          = 50.0  from (0:inf); // process node (nm)

    // ── Internal electrical nodes — tier interconnects ────────────────────────
    electrical t0_in_a,  t0_in_b,  t0_voted;
    electrical t1_in_a,  t1_in_b,  t1_voted;
    electrical t2_in_a,  t2_in_b,  t2_voted;
    electrical t3_in_a,  t3_in_b,  t3_voted;
    electrical t0_fault, t1_fault, t2_fault, t3_fault;
    electrical vcsel_comp;

    // ── VCSEL sub-instance ────────────────────────────────────────────────────
    vcsel_shg_thg vcsel_cell(
        .anode(vcsel_anode),   .cathode(vcsel_cathode),
        .out_850nm(vcsel_out_850), .out_425nm(vcsel_out_425),
        .out_283nm(vcsel_out_283),
        .heater_p(heater_t0),  .heater_n(heater_t3),
        .bias_pad(vcsel_cathode)
    );
    defparam vcsel_cell.vcsel_lambda_nm = vcsel_lambda_nm;
    defparam vcsel_cell.shg_eta_norm    = freq_double_eta * 1e-3;
    defparam vcsel_cell.alpha_phase     = alpha_phase;
    defparam vcsel_cell.beta_amplitude  = beta_amplitude;
    defparam vcsel_cell.gamma_ppm_K     = gamma_ppm_K;
    defparam vcsel_cell.delta_nm_offset = delta_nm_offset;

    // ── Tier 3 — OPA waveguide element layer ──────────────────────────────────
    siph_gi3at_proxy tier3_proxy(
        .in_a(in_a),       .in_b(in_b),
        .voted_out(t3_voted),
        .vote_status(t3_fault),
        .fault_bus(t3_fault),
        .heater_drive(heater_t3)
    );
    defparam tier3_proxy.agree_threshold  = agree_threshold;
    defparam tier3_proxy.halt_on_disagree = 0;   // Tier 3: heal before escalate
    defparam tier3_proxy.gamma_ppm        = gamma_ppm_K;
    defparam tier3_proxy.delta_nm         = delta_nm_offset;

    // ── Tier 2 — MZI tile execution layer ────────────────────────────────────
    siph_gi3at_proxy tier2_proxy(
        .in_a(t3_voted),   .in_b(in_b),
        .voted_out(t2_voted),
        .vote_status(t2_fault),
        .fault_bus(t2_fault),
        .heater_drive(heater_t2)
    );
    defparam tier2_proxy.agree_threshold  = agree_threshold;
    defparam tier2_proxy.halt_on_disagree = 0;
    defparam tier2_proxy.gamma_ppm        = gamma_ppm_K;
    defparam tier2_proxy.delta_nm         = delta_nm_offset;

    // ── Tier 1 — Quadrant dispatch (4 × 256² blocks) ─────────────────────────
    siph_gi3at_proxy tier1_proxy(
        .in_a(t2_voted),   .in_b(in_b),
        .voted_out(t1_voted),
        .vote_status(t1_fault),
        .fault_bus(t1_fault),
        .heater_drive(heater_t1)
    );
    defparam tier1_proxy.agree_threshold  = agree_threshold;
    defparam tier1_proxy.halt_on_disagree = 0;
    defparam tier1_proxy.gamma_ppm        = gamma_ppm_K;
    defparam tier1_proxy.delta_nm         = delta_nm_offset;

    // ── Tier 0 — Master arbitration (global 1024²) ────────────────────────────
    siph_gi3at_proxy tier0_proxy(
        .in_a(t1_voted),   .in_b(in_b),
        .voted_out(t0_voted),
        .vote_status(t0_fault),
        .fault_bus(t0_fault),
        .heater_drive(heater_t0)
    );
    defparam tier0_proxy.agree_threshold  = agree_threshold;
    defparam tier0_proxy.halt_on_disagree = halt_on_disagree;  // Tier 0: hard HALT
    defparam tier0_proxy.gamma_ppm        = gamma_ppm_K;
    defparam tier0_proxy.delta_nm         = delta_nm_offset;

    // ── Analog top-level: aggregate fault bus + final output ─────────────────
    branch (result_out) b_result;
    branch (fault_bus)  b_fbus;
    branch (heal_trigger) b_heal;

    real fault_agg, heal_v;

    analog begin
        // Aggregate fault levels (worst tier wins)
        fault_agg = max(max(V(t0_fault), V(t1_fault)),
                        max(V(t2_fault), V(t3_fault)));
        V(b_fbus) <+ fault_agg;

        // Auto-heal: when heal_trigger is pulsed high, reset γ/δ across tiers
        // (in silicon: re-calibration FSM — here: analog signal passthrough)
        heal_v = V(b_heal);

        // Final voted result to output
        V(b_result) <+ V(t0_voted) * (1.0 - heal_v * 0.01);

        $strobe("GI3AT  op=%.0f  result=%.4f  fault=%.0f  heal=%.2f",
                V(op_ctrl), V(b_result), fault_agg, heal_v);
    end
endmodule
